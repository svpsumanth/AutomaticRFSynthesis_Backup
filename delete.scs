// Generated for: spectre
// Generated on: May 16 17:20:46 2022
// Design library name: Inverter
// Design cell name: single_inverter
// Design view name: schematic
simulator lang=spectre
parameters fingers=10
include "/cad/library/TSMC/65/gp/oa_pdk/tsmcN65/../models/spectre/crn65gplus_2d5_lk_v1d0.scs" section=tt_rfmos

M0 (OUTPUT INPUT GND GND) nch l=60n w=1.2e-07*fingers m=1 nf=fingers
M1 (OUTPUT INPUT VDD VDD) pch l=60n w=2.4e-07*fingers m=1 nf=fingers

dcOp dc write="spectre.dc" maxiters=150 maxsteps=10000 annotate=status
dcOpInfo info what=oppoint where=rawfile
